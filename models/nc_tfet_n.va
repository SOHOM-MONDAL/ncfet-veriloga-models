`include "constants.vams"
`include "disciplines.vams"

module nc_tfet_n(d, g, s, b);

    inout d, g, s, b;
    electrical d, g, s, b;

    //============================================================
    // DEVICE GEOMETRY
    //============================================================

    parameter real W       = 1.0u;
    parameter real LCH     = 10n;
    parameter real TSI     = 10n;

    parameter real LSOURCE = 20n;
    parameter real LDRAIN  = 20n;

    //============================================================
    // MATERIAL PARAMETERS
    //============================================================

    parameter real TOX = 1n;
    parameter real TFE = 5n;

    parameter real EPS_SI = 11.7;
    parameter real EPS_OX = 3.9;
    parameter real EPS_FE = 25.0;

    parameter real EG = 1.12;

    // Effective tunneling mass
    parameter real M_TUN = 0.20;

    //============================================================
    // DOPING PARAMETERS
    //============================================================

    parameter real NSOURCE  = 8.0e19;
    parameter real NCHANNEL = 5.0e17;
    parameter real NDRAIN   = 5.0e18;

    //============================================================
    // GATE PARAMETERS
    //============================================================

    parameter real PHI_M = 4.10;
    parameter real VFB   = 0.0;

    //============================================================
    // BTBT / KANE PARAMETERS
    //
    // These parameters must be calibrated using TCAD.
    //============================================================

    // CHANGED: Scaled down from 1.0e27 to prevent kA-level current explosion
    parameter real A_BTBT = 1.0e19;
    parameter real B_BTBT = 2.0e7;

    parameter real BTBT_POWER = 2.0;

    // Effective tunneling length
    parameter real LTUN = 3n;

    //============================================================
    // SOURCE-DRAIN DIRECT TUNNELING
    //============================================================

    parameter real A_SDT = 1.0e-9;
    parameter real B_SDT = 1.0e9;

    //============================================================
    // NEGATIVE CAPACITANCE
    //============================================================

    // CHANGED: Scaled to -0.01 to correctly match the capacitance per-unit-area units
    parameter real CFE0 = -0.01;

    parameter real FE_NONLIN = 1.0e-3;

    //============================================================
    // TEMPERATURE PARAMETERS
    //============================================================

    parameter real TNOM = 300.0;

    parameter real EG_TEMP_COEFF = 4.73e-4;

    //============================================================
    // JUNCTION CAPACITANCE PARAMETERS
    //============================================================

    parameter real CJ0 = 1e-3;
    parameter real VJ  = 0.7;
    parameter real MJ  = 0.5;

    //============================================================
    // INTERNAL VARIABLES
    //============================================================

    real temperature;
    real VT;

    real epssi;
    real epsox;
    real epsfe;

    real Cox;
    real Csi;
    real Cbase;

    real Cfe;
    real Ctot;

    real VGS;
    real VDS;
    real VBS;

    real VDB;
    real VSB;

    real VG_INT;
    real phi_s;
    real E_tun;

    real Eg_T;

    real R_BTBT;
    real I_BTBT;

    real I_SDT;
    real I_TOTAL;

    real QCH;
    real QFE;

    real QG;
    real QD;
    real QS;
    real QB;

    real QDB;
    real QSB;

    real CDB;
    real CSB;

    //============================================================
    // ANALOG MODEL
    //============================================================

    analog begin

        //========================================================
        // TEMPERATURE
        //========================================================

        temperature = $temperature;

        VT = `P_K * temperature / `P_Q;

        //========================================================
        // MATERIAL PERMITTIVITY
        //========================================================

        epssi = EPS_SI * `P_EPS0;
        epsox = EPS_OX * `P_EPS0;
        epsfe = EPS_FE * `P_EPS0;

        //========================================================
        // TERMINAL VOLTAGES
        //========================================================

        VGS = V(g,s);
        VDS = V(d,s);
        VBS = V(b,s);

        VDB = V(d,b);
        VSB = V(s,b);

        //========================================================
        // OXIDE CAPACITANCE PER UNIT AREA
        //========================================================

        Cox = epsox / TOX;

        //========================================================
        // SILICON BODY CAPACITANCE PER UNIT AREA
        //========================================================

        Csi = epssi / TSI;

        //========================================================
        // SERIES OXIDE + SILICON CAPACITANCE
        //========================================================

        Cbase = (Cox * Csi) / (Cox + Csi);

        //========================================================
        // NEGATIVE CAPACITANCE
        //
        // Effective bias-dependent approximation.
        //========================================================

        Cfe = CFE0 /
              (1.0 + FE_NONLIN * abs(VGS));

        //========================================================
        // SERIES COMBINATION
        //========================================================

        if (abs(Cbase + Cfe) > 1.0e-30)
            Ctot = (Cbase * Cfe) /
                   (Cbase + Cfe);
        else
            Ctot = 1.0e-30;

        //========================================================
        // INTERNAL GATE VOLTAGE
        //
        // Negative-capacitance voltage amplification
        //========================================================

        if (abs(1.0 + Cbase/Cfe) > 1.0e-12)
            VG_INT = VGS /
                     (1.0 + Cbase/Cfe);
        else
            VG_INT = VGS;

        //========================================================
        // SURFACE POTENTIAL
        //========================================================

        phi_s = VG_INT - VFB;

        if (phi_s < 0.0)
            phi_s = 0.0;

        //========================================================
        // TEMPERATURE-DEPENDENT BANDGAP
        //========================================================

        Eg_T = EG -
               EG_TEMP_COEFF *
               (temperature - TNOM);

        if (Eg_T < 0.1)
            Eg_T = 0.1;

        //========================================================
        // TUNNELING ELECTRIC FIELD
        //========================================================

        if (LTUN > 1.0e-15)
            E_tun = phi_s / LTUN;
        else
            E_tun = 1.0;

        if (E_tun < 1.0)
            E_tun = 1.0;

        //========================================================
        // KANE-TYPE BTBT GENERATION
        //
        // R_BTBT = A * E^P * exp(-B/E)
        //========================================================

        R_BTBT =
            A_BTBT *
            pow(E_tun, BTBT_POWER) *
            exp(-B_BTBT/E_tun);

        //========================================================
        // BTBT CURRENT
        //
        // I_BTBT = q * W * LTUN * TSI * R_BTBT
        //========================================================

        I_BTBT =
            `P_Q *
            W *
            LTUN *
            TSI *
            R_BTBT;

        //========================================================
        // SOURCE-DRAIN DIRECT TUNNELING
        //========================================================

        I_SDT =
            A_SDT *
            W *
            exp(-B_SDT * LCH) *
            abs(VDS);

        //========================================================
        // TOTAL CURRENT
        //========================================================

        // CHANGED: Added drain saturation dependency (tanh) to prevent flatline current
        I_TOTAL = I_BTBT * tanh(VDS / 0.1) + I_SDT;

        //========================================================
        // DRAIN-SOURCE CURRENT CONTRIBUTION
        //========================================================

        I(d,s) <+ I_TOTAL;

        //========================================================
        // CHANNEL CHARGE
        //========================================================

        QCH =
            -Ctot *
            W *
            LCH *
            VG_INT;

        //========================================================
        // FERROELECTRIC CHARGE
        //========================================================

        QFE =
            Cfe *
            W *
            LCH *
            VG_INT;

        //========================================================
        // TERMINAL CHARGE PARTITION
        //========================================================

        QG = -(QCH + QFE);

        QD = 0.5 * QCH;

        QS = 0.5 * QCH;

        //========================================================
        // BODY CHARGE
        //
        // Enforce:
        //
        // QG + QD + QS + QB = 0
        //========================================================

        QB = -(QG + QD + QS);

        //========================================================
        // DRAIN-BODY JUNCTION CAPACITANCE
        //========================================================

        if ((1.0 - VDB/VJ) > 0.01) begin

            CDB =
                CJ0 *
                W *
                LCH *
                pow(
                    1.0 - VDB/VJ,
                    -MJ
                );

        end
        else begin

            CDB =
                CJ0 *
                W *
                LCH *
                pow(0.01,-MJ);

        end

        //========================================================
        // SOURCE-BODY JUNCTION CAPACITANCE
        //========================================================

        if ((1.0 - VSB/VJ) > 0.01) begin

            CSB =
                CJ0 *
                W *
                LCH *
                pow(
                    1.0 - VSB/VJ,
                    -MJ
                );

        end
        else begin

            CSB =
                CJ0 *
                W *
                LCH *
                pow(0.01,-MJ);

        end

        //========================================================
        // JUNCTION CHARGES
        //========================================================

        QDB = CDB * VDB;

        QSB = CSB * VSB;

        //========================================================
        // CHARGE-BASED TERMINAL CURRENTS
        //========================================================

        I(g) <+ ddt(QG);

        I(d) <+ ddt(QD + QDB);

        I(s) <+ ddt(QS + QSB);

        I(b) <+ ddt(QB - QDB - QSB);

    end

endmodule
